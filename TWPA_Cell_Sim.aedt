# Ansys Electronics Desktop project, version 2022.2
project variables:
  $z_gnd = 200nm
  $z_sub = 625um
  $z_cell = 200nm
  $frame_width = 90u
  $cell_width = 5*$junction_width
  $cell_height = 236um
  $r = 0.1
  $junction_height = 2um
  $junction_width = 0.85um
  $z_suspension = 100nm
  $chip_width = 1mm
  $cop_gnd_gap = $cell_height+2*$finger_pad
  $snail_gap_height = 70um
  $finger_length = 0.1u
  $finger_pad = 8um
  $finger_width = 1um
  $finger_gap = 10um
  $snail_cap_width = 25um
  $snail_cap_height = 5um
  $snail_cap_lead_width = $snail_cap_width/3
  $finger_length_long = 50u
  $soder_ball_radius = 0.06m
  $channel_width = 55um
  $taper_length = 100um
  $pad_width = 50um
  $pad_height = 30um
  $snail_frame_height = 14um
  $num_fingers = 4
materials:
  vacuum: permittivity=1
  copper: permeability=0.999991 conductivity=58000000
  silicon: permittivity=11.9
  aluminum: permeability=1.000021 conductivity=38000000
  pec: conductivity=1e+30
  perfect conductor: conductivity=1e+30

design tapered_idc (Q3D Extractor, model units mm)
options: SParamCalcMethod=EqTransLine Calculate_Lossy_Dielectrics
geometry:
  pad [pec] = box(corner=($pad_height/2, -$pad_width/2, 0mm), size=(-$pad_height, $pad_width, $z_cell))
  input_taper_bottom [pec] = box(corner=($pad_height/2, $pad_width/2, 0mm), size=(-$pad_height/2, $taper_length, $z_cell))
  input_taper_bottom.chamfer(Edges=input_taper_bottom.edge(12 of 12) LeftDistance=atan(($pad_height/2-$snail_frame_height/2)/$taper_length) RightDistance=$taper_length ChamferType="Right Distance-Angle")
  input_taper_top [pec] = input_taper_bottom.duplicate_mirror(point=(0mm, 0.2mm, 0mm), normal=(-1mm, 0mm, 0mm))
  output_taper_top [pec] = input_taper_bottom.duplicate_around_axis(axis=Z, angle=180deg, total=2)
  output_taper_bottom [pec] = input_taper_top.duplicate_around_axis(axis=Z, angle=180deg, total=2)
  finger [pec] = box(corner=($pad_height/2, -($num_fingers/2*$finger_width+($num_fingers-1)/2*($finger_gap)), 0mm), size=($finger_length, $finger_width, $z_cell))
  finger_1, finger_2, finger_3 [pec] = finger.duplicate_along_line(step=(0mm, $finger_gap +$finger_width, 0mm), total=4)
  finger_4 [pec] = finger.duplicate_mirror(point=(0mm, 0mm, 0mm), normal=(-1mm, 0mm, 0mm))
  finger_1_1 [pec] = finger_1.duplicate_mirror(point=(0mm, 0mm, 2e-05mm), normal=(-1mm, 0mm, 0mm))
  finger_2_1 [pec] = finger_2.duplicate_mirror(point=(0mm, 0mm, 2e-05mm), normal=(-1mm, 0mm, 0mm))
  finger_3_1 [pec] = finger_3.duplicate_mirror(point=(0mm, 0mm, 2e-05mm), normal=(-1mm, 0mm, 0mm))
  pad1 [vacuum] = box(corner=($pad_height/2+$finger_pad, -$pad_width/2, 0mm), size=(-$pad_height-2*$finger_pad, $pad_width, $z_cell))
  input_taper_bottom1 [vacuum] = box(corner=($pad_height/2+$finger_pad, $pad_width/2, 0mm), size=(-$pad_height/2-$finger_pad, $taper_length+$finger_pad, $z_cell))
  input_taper_bottom1.chamfer(Edges=input_taper_bottom1.edge(12 of 12) LeftDistance=atan(($pad_height/2-$snail_frame_height/2)/$taper_length) RightDistance=$taper_length ChamferType="Right Distance-Angle")
  input_taper_top1 [vacuum] = input_taper_bottom1.duplicate_mirror(point=(0mm, 0.2mm, 0mm), normal=(-1mm, 0mm, 0mm))
  output_taper_top1 [vacuum] = input_taper_bottom1.duplicate_around_axis(axis=Z, angle=180deg, total=2)
  output_taper_bottom1 [vacuum] = input_taper_top1.duplicate_around_axis(axis=Z, angle=180deg, total=2)
  finger1 [vacuum] = box(corner=($pad_height/2, -($num_fingers/2*$finger_width+($num_fingers-1)/2*($finger_gap))-$finger_pad, 0mm), size=($finger_length+$finger_pad, $finger_width+2*$finger_pad, $z_cell))
  finger_5, finger_6, finger_7 [vacuum] = finger1.duplicate_along_line(step=(0mm, $finger_gap +$finger_width, 0mm), total=4)
  finger_8 [vacuum] = finger1.duplicate_mirror(point=(0mm, 0mm, 0mm), normal=(-1mm, 0mm, 0mm))
  finger_1_2 [vacuum] = finger_5.duplicate_mirror(point=(0mm, 0mm, 2e-05mm), normal=(-1mm, 0mm, 0mm))
  finger_2_2 [vacuum] = finger_6.duplicate_mirror(point=(0mm, 0mm, 2e-05mm), normal=(-1mm, 0mm, 0mm))
  finger_3_2 [vacuum] = finger_7.duplicate_mirror(point=(0mm, 0mm, 2e-05mm), normal=(-1mm, 0mm, 0mm))
  group Taper_Group = input_taper_bottom, input_taper_top, output_taper_top, output_taper_bottom
  group Finger_Group = finger, finger_1..finger_4, finger_1_1, finger_2_1, finger_3_1
  group Pad_Group = pad
  group Taper_Group_Etch = input_taper_bottom1, input_taper_top1, output_taper_top1, output_taper_bottom1
  group Finger_Group_Etch = finger1, finger_5..finger_8, finger_1_2, finger_2_2, finger_3_2
  group Pad_Group_Etch = pad1

design Flip_chip_taper_cell (Q3D Extractor, model units um)
options: SParamCalcMethod=EqTransLine Calculate_Lossy_Dielectrics
geometry:
  coplanar_gnd = box(corner=((($chip_width/2)*0.001)*1000.0000000000001, ((-$chip_width/2)*0.001)*1000.0000000000001, 0), size=(((-$chip_width)*0.001)*1000.0000000000001, (($chip_width)*0.001)*1000.0000000000001, (($z_cell)*0.001)*1000.0000000000001))
  substrate [silicon] = box(corner=((($chip_width/2)*0.001)*1000.0000000000001, ((-$chip_width/2)*0.001)*1000.0000000000001, ((-$z_sub)*0.001)*1000.0000000000001), size=(((-$chip_width)*0.001)*1000.0000000000001, (($chip_width)*0.001)*1000.0000000000001, (($z_sub)*0.001)*1000.0000000000001))
  pad = box(corner=((($pad_height/2)*0.001)*1000.0000000000001, ((-$pad_width/2)*0.001)*1000.0000000000001, 0um), size=(((-$pad_height)*0.001)*1000.0000000000001, (($pad_width)*0.001)*1000.0000000000001, (($z_cell)*0.001)*1000.0000000000001))
  input_taper_bottom = box(corner=((($pad_height/2)*0.001)*1000.0000000000001, (($pad_width/2)*0.001)*1000.0000000000001, 0um), size=(((-$pad_height/2)*0.001)*1000.0000000000001, (($taper_length)*0.001)*1000.0000000000001, (($z_cell)*0.001)*1000.0000000000001))
  input_taper_bottom.chamfer(Edges=pad.edge(12 of 12) LeftDistance=atan(($pad_height/2-$snail_frame_height/2)/$taper_length) RightDistance=(($taper_length)*0.001)*1000.0000000000001 ChamferType="Right Distance-Angle")
  input_taper_top = input_taper_bottom.duplicate_mirror(point=(0um, 200um, 0um), normal=(-1000um, 0um, 0um))
  output_taper_top = input_taper_bottom.duplicate_around_axis(axis=Z, angle=180deg, total=2)
  output_taper_bottom = input_taper_top.duplicate_around_axis(axis=Z, angle=180deg, total=2)
  finger = box(corner=((($pad_height/2)*0.001)*1000.0000000000001, ((-($num_fingers/2*$finger_width+($num_fingers-1)/2*($finger_gap)))*0.001)*1000.0000000000001, 0um), size=((($finger_length)*0.001)*1000.0000000000001, (($finger_width)*0.001)*1000.0000000000001, (($z_cell)*0.001)*1000.0000000000001))
  finger_1, finger_2, finger_3 = finger.duplicate_along_line(step=(0um, (($finger_gap +$finger_width)*0.001)*1000.0000000000001, 0um), total=4)
  finger_4 = finger.duplicate_mirror(point=(0um, 0um, 0um), normal=(-1000um, 0um, 0um))
  finger_1_1 = finger_1.duplicate_mirror(point=(0um, 0um, 0.02um), normal=(-1000um, 0um, 0um))
  finger_2_1 = finger_2.duplicate_mirror(point=(0um, 0um, 0.02um), normal=(-1000um, 0um, 0um))
  finger_3_1 = finger_3.duplicate_mirror(point=(0um, 0um, 0.02um), normal=(-1000um, 0um, 0um))
  pad1 = box(corner=((($pad_height/2+$finger_pad)*0.001)*1000.0000000000001, ((-$pad_width/2)*0.001)*1000.0000000000001, 0um), size=(((-$pad_height-2*$finger_pad)*0.001)*1000.0000000000001, (($pad_width)*0.001)*1000.0000000000001, (($z_cell)*0.001)*1000.0000000000001))
  input_taper_bottom1 = box(corner=((($pad_height/2+$finger_pad)*0.001)*1000.0000000000001, (($pad_width/2)*0.001)*1000.0000000000001, 0um), size=(((-$pad_height/2-$finger_pad)*0.001)*1000.0000000000001, (($taper_length+$finger_pad)*0.001)*1000.0000000000001, (($z_cell)*0.001)*1000.0000000000001))
  input_taper_bottom1.chamfer(Edges=pad1.edge(12 of 12) LeftDistance=atan(($pad_height/2-$snail_frame_height/2)/$taper_length) RightDistance=(($taper_length)*0.001)*1000.0000000000001 ChamferType="Right Distance-Angle")
  input_taper_top1 = input_taper_bottom1.duplicate_mirror(point=(0um, 200um, 0um), normal=(-1000um, 0um, 0um))
  output_taper_top1 = input_taper_bottom1.duplicate_around_axis(axis=Z, angle=180deg, total=2)
  output_taper_bottom1 = input_taper_top1.duplicate_around_axis(axis=Z, angle=180deg, total=2)
  finger1 = box(corner=((($pad_height/2)*0.001)*1000.0000000000001, ((-($num_fingers/2*$finger_width+($num_fingers-1)/2*($finger_gap))-$finger_pad)*0.001)*1000.0000000000001, 0um), size=((($finger_length+$finger_pad)*0.001)*1000.0000000000001, (($finger_width+2*$finger_pad)*0.001)*1000.0000000000001, (($z_cell)*0.001)*1000.0000000000001))
  finger_5, finger_6, finger_7 = finger1.duplicate_along_line(step=(0um, (($finger_gap +$finger_width)*0.001)*1000.0000000000001, 0um), total=4)
  finger_8 = finger1.duplicate_mirror(point=(0um, 0um, 0um), normal=(-1000um, 0um, 0um))
  finger_1_2 = finger_5.duplicate_mirror(point=(0um, 0um, 0.02um), normal=(-1000um, 0um, 0um))
  finger_2_2 = finger_6.duplicate_mirror(point=(0um, 0um, 0.02um), normal=(-1000um, 0um, 0um))
  finger_3_2 = finger_7.duplicate_mirror(point=(0um, 0um, 0.02um), normal=(-1000um, 0um, 0um))
  suspended_gnd = box(corner=((($chip_width/2)*0.001)*1000.0000000000001, ((-$chip_width/2)*0.001)*1000.0000000000001, (($z_cell+$z_suspension)*0.001)*1000.0000000000001), size=(((-$chip_width)*0.001)*1000.0000000000001, (($chip_width)*0.001)*1000.0000000000001, (($z_gnd)*0.001)*1000.0000000000001))
  chip_vac [vacuum] = box(corner=((($chip_width/2)*0.001)*1000.0000000000001, ((-$chip_width/2)*0.001)*1000.0000000000001, ((-$z_sub)*0.001)*1000.0000000000001), size=(((-$chip_width)*0.001)*1000.0000000000001, (($chip_width)*0.001)*1000.0000000000001, 1000um))
  substrate1 = box(corner=((($chip_width/2)*0.001)*1000.0000000000001, ((-$chip_width/2)*0.001)*1000.0000000000001, ((-$z_sub)*0.001)*1000.0000000000001), size=(((-$chip_width)*0.001)*1000.0000000000001, (($chip_width)*0.001)*1000.0000000000001, (($z_sub)*0.001)*1000.0000000000001))
  chip_vac.subtract(substrate1)
  pad1.unite(input_taper_bottom1, input_taper_top1, output_taper_bottom1, output_taper_top1, finger1, finger_8, finger_7, finger_6, finger_5, finger_3_2, finger_2_2, finger_1_2)
  pad.unite(input_taper_bottom, input_taper_top, output_taper_bottom, output_taper_top, finger_4, finger_3_1, finger_3, finger_2_1, finger_2, finger_1_1, finger_1, finger)
  coplanar_gnd.subtract(pad1)
  pad_ObjectFromFace1 [pec] = object_from(pad.face(-z))
  pad.delete()
  coplanar_gnd_ObjectFromFace1 [pec] = object_from(coplanar_gnd.face(-z))
  coplanar_gnd.delete()
  suspended_gnd_ObjectFromFace1 [pec] = object_from(suspended_gnd.face(-z))
  suspended_gnd.delete()
  group Die = substrate, coplanar_gnd_ObjectFromFace1, suspended_gnd_ObjectFromFace1
  group Pad_Group = pad_ObjectFromFace1
boundaries and excitations:
  suspended_gnd: GroundNet Objects=suspended_gnd_ObjectFromFace1
  superconductor: ThinConductor Objects=[pad_ObjectFromFace1, suspended_gnd_ObjectFromFace1, coplanar_gnd_ObjectFromFace1] Material=pec Thickness=200nm
  pad: SignalNet Objects=pad_ObjectFromFace1
  coplanar_gnd: GroundNet Objects=coplanar_gnd_ObjectFromFace1
  cell_input: Source Edges=pad_ObjectFromFace1.edge(at (0, 125, 0)) TerminalType=UniformCurrent Net=pad
  cell_output: Sink Edges=pad_ObjectFromFace1.edge(at (0, -125, 0)) TerminalType=UniformCurrent Net=pad
setups:
  capacitance: Matrix AdaptiveFreq=7.5GHz Cap{MaxPass=20 MinPass=1 MinConvPass=1 PerError=0.1 PerRefine=30 AutoIncreaseSolutionOrder SolutionOrder=High Solver_Type=Iterative} ErrorValue=0.1
  parasitic_inductance: Matrix AdaptiveFreq=1GHz AC{MaxPass=20 MinPass=1 MinConvPass=1 PerError=0.1 PerRefine=30} ErrorValue=0.1
source amplitudes:
  pad:cell_input: AC 1A
  pad: Cap 1V 0deg
  pad:cell_input: DC 1A
optimetrics:
  chip_separation: Parametric Sim._Setups=[capacitance]
    sweep $z_suspension: LIN 100nm 1um 100nm
  finger_length: Parametric Sim._Setups=[capacitance]
    sweep $finger_length: LIN 5e-06 3e-05 5e-06
  pad_width: Parametric Sim._Setups=[capacitance]
    sweep $pad_width: LIN 50um 150um 25um
reports:
  C Matrix Plot 1: C(pad,pad) vs $z_suspension on capacitance : LastAdaptive [Freq=7.5GHz $finger_length=1e-07 $pad_width=50um]

design Taper_cell (Q3D Extractor, model units um)
options: SParamCalcMethod=EqTransLine Calculate_Lossy_Dielectrics
geometry:
  coplanar_gnd = box(corner=((($chip_width/2)*0.001)*1000.0000000000001, ((-$chip_width/2)*0.001)*1000.0000000000001, 0), size=(((-$chip_width)*0.001)*1000.0000000000001, (($chip_width)*0.001)*1000.0000000000001, (($z_cell)*0.001)*1000.0000000000001))
  substrate [silicon] = box(corner=((($chip_width/2)*0.001)*1000.0000000000001, ((-$chip_width/2)*0.001)*1000.0000000000001, ((-$z_sub)*0.001)*1000.0000000000001), size=(((-$chip_width)*0.001)*1000.0000000000001, (($chip_width)*0.001)*1000.0000000000001, (($z_sub)*0.001)*1000.0000000000001))
  pad = box(corner=((($pad_height/2)*0.001)*1000.0000000000001, ((-$pad_width/2)*0.001)*1000.0000000000001, 0um), size=(((-$pad_height)*0.001)*1000.0000000000001, (($pad_width)*0.001)*1000.0000000000001, (($z_cell)*0.001)*1000.0000000000001))
  input_taper_bottom = box(corner=((($pad_height/2)*0.001)*1000.0000000000001, (($pad_width/2)*0.001)*1000.0000000000001, 0um), size=(((-$pad_height/2)*0.001)*1000.0000000000001, (($taper_length)*0.001)*1000.0000000000001, (($z_cell)*0.001)*1000.0000000000001))
  input_taper_bottom.chamfer(Edges=pad.edge(12 of 12) LeftDistance=atan(($pad_height/2-$snail_frame_height/2)/$taper_length) RightDistance=(($taper_length)*0.001)*1000.0000000000001 ChamferType="Right Distance-Angle")
  input_taper_top = input_taper_bottom.duplicate_mirror(point=(0um, 200um, 0um), normal=(-1000um, 0um, 0um))
  output_taper_top = input_taper_bottom.duplicate_around_axis(axis=Z, angle=180deg, total=2)
  output_taper_bottom = input_taper_top.duplicate_around_axis(axis=Z, angle=180deg, total=2)
  finger = box(corner=((($pad_height/2)*0.001)*1000.0000000000001, ((-($num_fingers/2*$finger_width+($num_fingers-1)/2*($finger_gap)))*0.001)*1000.0000000000001, 0um), size=((($finger_length)*0.001)*1000.0000000000001, (($finger_width)*0.001)*1000.0000000000001, (($z_cell)*0.001)*1000.0000000000001))
  finger_1, finger_2, finger_3 = finger.duplicate_along_line(step=(0um, (($finger_gap +$finger_width)*0.001)*1000.0000000000001, 0um), total=4)
  finger_4 = finger.duplicate_mirror(point=(0um, 0um, 0um), normal=(-1000um, 0um, 0um))
  finger_1_1 = finger_1.duplicate_mirror(point=(0um, 0um, 0.02um), normal=(-1000um, 0um, 0um))
  finger_2_1 = finger_2.duplicate_mirror(point=(0um, 0um, 0.02um), normal=(-1000um, 0um, 0um))
  finger_3_1 = finger_3.duplicate_mirror(point=(0um, 0um, 0.02um), normal=(-1000um, 0um, 0um))
  pad1 = box(corner=((($pad_height/2+$finger_pad)*0.001)*1000.0000000000001, ((-$pad_width/2)*0.001)*1000.0000000000001, 0um), size=(((-$pad_height-2*$finger_pad)*0.001)*1000.0000000000001, (($pad_width)*0.001)*1000.0000000000001, (($z_cell)*0.001)*1000.0000000000001))
  input_taper_bottom1 = box(corner=((($pad_height/2+$finger_pad)*0.001)*1000.0000000000001, (($pad_width/2)*0.001)*1000.0000000000001, 0um), size=(((-$pad_height/2-$finger_pad)*0.001)*1000.0000000000001, (($taper_length+$finger_pad)*0.001)*1000.0000000000001, (($z_cell)*0.001)*1000.0000000000001))
  input_taper_bottom1.chamfer(Edges=pad1.edge(12 of 12) LeftDistance=atan(($pad_height/2-$snail_frame_height/2)/$taper_length) RightDistance=(($taper_length)*0.001)*1000.0000000000001 ChamferType="Right Distance-Angle")
  input_taper_top1 = input_taper_bottom1.duplicate_mirror(point=(0um, 200um, 0um), normal=(-1000um, 0um, 0um))
  output_taper_top1 = input_taper_bottom1.duplicate_around_axis(axis=Z, angle=180deg, total=2)
  output_taper_bottom1 = input_taper_top1.duplicate_around_axis(axis=Z, angle=180deg, total=2)
  finger1 = box(corner=((($pad_height/2)*0.001)*1000.0000000000001, ((-($num_fingers/2*$finger_width+($num_fingers-1)/2*($finger_gap))-$finger_pad)*0.001)*1000.0000000000001, 0um), size=((($finger_length+$finger_pad)*0.001)*1000.0000000000001, (($finger_width+2*$finger_pad)*0.001)*1000.0000000000001, (($z_cell)*0.001)*1000.0000000000001))
  finger_5, finger_6, finger_7 = finger1.duplicate_along_line(step=(0um, (($finger_gap +$finger_width)*0.001)*1000.0000000000001, 0um), total=4)
  finger_8 = finger1.duplicate_mirror(point=(0um, 0um, 0um), normal=(-1000um, 0um, 0um))
  finger_1_2 = finger_5.duplicate_mirror(point=(0um, 0um, 0.02um), normal=(-1000um, 0um, 0um))
  finger_2_2 = finger_6.duplicate_mirror(point=(0um, 0um, 0.02um), normal=(-1000um, 0um, 0um))
  finger_3_2 = finger_7.duplicate_mirror(point=(0um, 0um, 0.02um), normal=(-1000um, 0um, 0um))
  chip_vac [vacuum] = box(corner=((($chip_width/2)*0.001)*1000.0000000000001, ((-$chip_width/2)*0.001)*1000.0000000000001, ((-$z_sub)*0.001)*1000.0000000000001), size=(((-$chip_width)*0.001)*1000.0000000000001, (($chip_width)*0.001)*1000.0000000000001, 1000um))
  substrate1 = box(corner=((($chip_width/2)*0.001)*1000.0000000000001, ((-$chip_width/2)*0.001)*1000.0000000000001, ((-$z_sub)*0.001)*1000.0000000000001), size=(((-$chip_width)*0.001)*1000.0000000000001, (($chip_width)*0.001)*1000.0000000000001, (($z_sub)*0.001)*1000.0000000000001))
  chip_vac.subtract(substrate1)
  pad1.unite(input_taper_bottom1, input_taper_top1, output_taper_bottom1, output_taper_top1, finger1, finger_8, finger_7, finger_6, finger_5, finger_3_2, finger_2_2, finger_1_2)
  pad.unite(input_taper_bottom, input_taper_top, output_taper_bottom, output_taper_top, finger_4, finger_3_1, finger_3, finger_2_1, finger_2, finger_1_1, finger_1, finger)
  coplanar_gnd.subtract(pad1)
  pad_ObjectFromFace1 [pec] = object_from(pad.face(-z))
  pad.delete()
  coplanar_gnd_ObjectFromFace1 [pec] = object_from(coplanar_gnd.face(-z))
  coplanar_gnd.delete()
  group Die = substrate, coplanar_gnd_ObjectFromFace1
  group Pad_Group = pad_ObjectFromFace1
boundaries and excitations:
  superconductor: ThinConductor Objects=[pad_ObjectFromFace1, coplanar_gnd_ObjectFromFace1] Material=pec Thickness=200nm
  pad: SignalNet Objects=pad_ObjectFromFace1
  coplanar_gnd: GroundNet Objects=coplanar_gnd_ObjectFromFace1
  cell_input: Source Edges=pad_ObjectFromFace1.edge(at (0, 125, 0)) TerminalType=UniformCurrent Net=pad
  cell_output: Sink Edges=pad_ObjectFromFace1.edge(at (0, -125, 0)) TerminalType=UniformCurrent Net=pad
setups:
  capacitance: Matrix AdaptiveFreq=7.5GHz Cap{MaxPass=20 MinPass=1 MinConvPass=1 PerError=0.1 PerRefine=30 AutoIncreaseSolutionOrder SolutionOrder=High Solver_Type=Iterative} ErrorValue=0.1
  parasitic_inductance: Matrix AdaptiveFreq=1GHz AC{MaxPass=20 MinPass=1 MinConvPass=1 PerError=0.1 PerRefine=30} ErrorValue=0.1
source amplitudes:
  pad:cell_input: AC 1A
  pad: Cap 1V 0deg
  pad:cell_input: DC 1A
optimetrics:
  chip_separation: Parametric Sim._Setups=[capacitance]
    sweep $z_suspension: LIN 100nm 300nm 50nm
  finger_length: Parametric Sim._Setups=[capacitance]
    sweep $finger_length: LIN 5e-06 3e-05 5e-06
  pad_width: Parametric Sim._Setups=[capacitance]
    sweep $pad_width: LIN 50um 150um 25um
